/*
EKV MOS model version 2.6 rev.15 with documentation at: http://ekv.epfl.ch
Matthias Bucher, Christophe Lallement, Christian Enz, Fabien Theodoloz, Francois Krummenacher
Electronics Laboratories, Swiss Federal Institute of Technology Lausanne, Switzerland
This Verilog-A was developed by Wladek Grabinski with modifications
by Tiburon Design Automation (www.tiburon-da.com).
This software has been provided pursuant to a License Agreement containing restrictions on its use.
It may not be copied or distributed in any form or medium, disclosed to third parties,
reverse engineered or used in any manner not provided for in said License Agreement
except with the prior written authorization.
Licensed under the Educational Community License, Version 2.0 (the "License");
you may not use this file except in compliance with the License.

You may obtain a copy of the License at http://opensource.org/licenses/ECL-2.0

Unless required by applicable law or agreed to in writing, software distributed under
the License is distributed on an "AS IS" BASIS, WITHOUT WARRANTIES OR CONDITIONS OF ANY KIND,
either express or implied. See the License for the specific language governing permissions
and limitations under the License.

$RCSfile: ekv.va,v $ $Revision: 1.9 $    $Date: 2003/12/17 01:20:10 $
$RCSfile: ekv.va,v $ $Revision: 2.6.15 $ $Date: 2020/05/29 11:50:10 $
*/
`include "disciplines.vams"
`include "constants.vams"
`include "generalMacrosAndDefines.va"

`ifdef insideADMS
    `define INITIAL_MODEL @(initial_model)
    `define INITIAL_INSTANCE @(initial_instance)
`else
    `define INITIAL_MODEL
    `define INITIAL_INSTANCE
`endif

//------------------------------------------ end of includes
`define FWD 1
`define REV -1
// AB 040902
`define DEFAULT_TNOM 27

//`define GMIN        1.0e-12
`define GMIN        $simparam("gmin",1e-12)  //suggested by L.L

`define y_fv(tmp1,yk) \
    if (tmp1 > -0.35) begin \
        z0  = 2.0/(1.3 + tmp1 - ln(tmp1 + 1.6)); \
        zk  = (2.0 + z0)/(1.0 + tmp1 + ln(z0)); \
        yk  = (1.0 + tmp1 + ln(zk))/(2.0 + zk); \
    end \
    else begin \
        if (tmp1 > -15.0) begin \
            z0  = 1.55 + exp(-tmp1); \
            zk  = (2.0 + z0)/(1.0 + tmp1 + ln(z0)); \
            yk  = (1.0 + tmp1 + ln(zk))/(2.0 + zk); \
        end \
        else begin \
            if (tmp1 > -23.0) begin \
                yk  = 1.0/(2.0 + exp(-tmp1)); \
            end \
            else begin \
                yk  = exp(tmp1) + 1E-64; \
            end \
        end \
    end

module ekv26_va(d,g,s,b);
    // %%DEVICE_CLASS=MOS(NMOS:TYPE=1,PMOS:TYPE=-1)%%
    //  Node definitions
    inout           d,g,s,b;         // external nodes
    electrical      d,g,s,b;         // external nodes
    //      Branch definitions
    branch (d,s)    ds;
    branch (d,b)    db;
    branch (s,b)    sb;
    branch (g,b)    gb;
    // * Local variables
    real tmp1, tmp2, tmp3; // temporary variables
    real VGprime, GAMMAprime;// short and narrow channel effect
    real VP, VPprime;    // pinch-off voltage
    real if_, ir, irprime;   // normalized currents
    real VDSS, VDSSprime;// saturation voltage
    real deltaL, Leq;    // channel length reduction
    real beta;           // transconductance factor
    real nslope;         // slope factor
//    real Ispec;          // specific current // CE 24/09/20 Disabled because added in .OP statement
    real Vt, Vtn;        // k*T/q, Vt*n
//    real gm, gms, gmbs, gds;
//    real gms; // CE 24/09/20 Disabled because added in .OP statement
    real isub, Isub;
    real inv_Vt, Vt_01, Vt_2, Vt_4, Vt_Vt, Vt_Vt_2, Vt_Vt_16;
    real eps_COX, eps_COX_W, eps_COX_L;
    real Lc, Lc_LAMBDA, IBN_2, T0, T1, eta_qi;
    real inv_UCRIT, Lc_UCRIT, Lc_IBB, IBA_IBB;
    integer Mode;
    real WETA_W, LETA_L;
    real E0_Q_1, AWL;
    real T, KP_Weff;
    real Eg, refEg, deltaT, ratioT, Tnom;
    real VTO_T, VTO_S, KP_T, UCRIT_T, IBB_T, PHI_T, GAMMA_S;
    real sqrt_Lprime_Lmin;
    real GAMMAstar, sqrt_GAMMAstar;
    real big_sqrt_VP;
    real big_sqrt_VP0, VP0;
    real PHI_VD, PHI_VS;
    real sqrt_PHI;
    real sqrt_PHI_VP, sqrt_PHI_VD, sqrt_PHI_VS;
    real sqrt_PHI_VD_Vt, sqrt_PHI_VS_Vt;
    real Vds, deltaV_2, Vip;
    real VDSS_sqrt, sqrt_VDSS_deltaV, sqrt_Vds_VDSS_deltaV;
    real VDSSprime_sqrt, sqrt_VDSSprime_deltaV, sqrt_Vds_VDSSprime_deltaV;
    real if_ir;
    real sqrt_if; // sqrt_ir, sqrt_irprime;
    real dif_dv, dir_dv, dirprime_dv;
    //  Charge related variables
    real sif, sir, sif2, sir2, sif3, sir3;
    real sif_sir_2;
    real qi, qb;
    real QD, QS, QI, QB, QG;
    real VP_PHI_eps, sqrt_PHI_VP_2, WLCox;
    real n_Vt_COX, n_1, n_1_n;
    //  Variables used for derivatives computation
    real dVP_dVD, dVP_dVG, dVP_dVS;
    real dif_dVD, dif_dVS, dif_dVG;
    real dir_dVD, dir_dVS, dir_dVG;
    real dVDSS_dVD, dVDSS_dVG, dVDSS_dVS;
    real ddeltaV_dVD, ddeltaV_dVG, ddeltaV_dVS;
    real dVip_dVD, dVip_dVG, dVip_dVS;
    real dVDSSprime_dVD, dVDSSprime_dVG, dVDSSprime_dVS;
    real dirprime_dVD, dirprime_dVG, dirprime_dVS;
    real dLeq_dVD, dLeq_dVG, dLeq_dVS;
    real dbeta_dVD, dbeta_dVG, dbeta_dVS;
    real VGstar, sqrt_VGstar;
    real VG, VD, VS;
//    real Von, Ibd;
    real Gn;
    real GAMMA_sqrt_PHI, Lmin, Lprime, T0_GAMMA_1, THETA_VP_1, Vc;
    real Vdsprime, Vt_Vc, dGAMMAprime_dVD, dGAMMAprime_dVG, dGAMMAprime_dVS;
    real dVPprime_dVD, dVPprime_dVG, dVPprime_dVS, ddeltaL_dVD, ddeltaL_dVG;
    real ddeltaL_dVS, dn_dVD, dn_dVG, dn_dVS;
    real log_Vc_Vt, sqrt_PHI_VP0, sqrt_VP_Vt;
    real Lc_IBB_Vib, Vib, exp_ib;//, dIsub_factor;
    real inv_Vib, sqrt_PHI_VP2_2;
    real V0, deltaVFB, vL;
    real dQI_dVD, dQI_dVS, dQI_dVG;
    real dQB_dVD, dQB_dVS, dQB_dVG;
    real Leff, Weff;
    real RSeff, RDeff;
    real yk, z0, zk;
    real epssil;
    real Qbdx, Qbsx;
    //DIODES realted variables [AB: 040902]
    real as_i, ad_i, ps_i, pd_i, v_di_b, v_si_b;
    real temp_arg, tmp0;
    real js_t, jsw_t, jswg_t;
    real pb_t, pbsw_t, pbswg_t;
    real cj_t, cjsw_t, cjswg_t;
    real njts_t, njtssw_t, njtsswg_t;
    real is_d, arg_d, is_s, arg_s;
    real f_breakdown_d, f_breakdown_s, idb_tun, isb_tun;
    real csb_d, cssw_d, csswg_d;
    real csb_s, cssw_s, csswg_s;
    real qjd, qjs;
    real qgso, qgdo, qgbo;

    // parameter definitions
    `MPIty( TYPE   , 1    , ""                                , "Channel type parameter, +1=NMOS -1=PMOS")
    `MPIcc( Noise  , 1    , ""      ,            0 ,   1      , "Set to zero to prevent noise calculation")
    `MPRco( TEMP   , 27.0 , "C"     , -`P_CELSIUS0 , inf      , "Device temperature")
    `MPRco( TNOM   , 27.0 , "C"     , -`P_CELSIUS0 , inf      , "Device nominal temperature")

    // Instance parameters

    // - intrinsic model
    `IPRoz( L     , 1.0e-5 , "m"                              , "Length" )
    `IPRoz( W     , 1.0e-5 , "m"                              , "Total width including fingers" )
    `IPIco( M     , 1      , ""       , 1           , inf     , "Parallel multiplier" )
    `IPIco( NS    , 1      , ""       , 1           , inf     , "Series multiplier" )
    `IPRoo( DTEMP , 0.0    , "K"      , -inf        , inf     , "Offset of device temperature" )
    //aliasparam Trise = DTEMP;
    // - external parasitics
    `IPRcz( AS   , 0.0     , "m^2"                            , "Source-to-substrate junction area" )
    `IPRcz( AD   , 0.0     , "m^2"                            , "Drain-to-substrate junction area" )
    `IPRcz( PS   , 0.0     , "m"                              , "Source-to-substrate junction perimeter" )
    `IPRcz( PD   , 0.0     , "m"                              , "Drain-to-substrate junction perimeter" )

    `IPRcz( NRS  , 1.0     , ""                               , "Number of squares in source" )
    `IPRcz( NRD  , 1.0     , ""                               , "Number of squares in drain" )

    // *** Process related parameters
    `MPRco( COX    ,  2.0E-3 , "F"     , 1e-21 , inf , "Gate oxide capacitance per unit area")
    `MPRco( XJ     ,  300E-9 , "m"     , 10e-9 , 2e-6 , "Junction depth")
    //*** Threshold voltage/substrate effect parameters (long-channel)
    `MPRoo( VTO    ,  0.5    , "V"     ,  -inf , inf , "Long-channel threshold voltage")
    `MPRnb( TCV    ,  1.0e-3 , "V/K"   ,               "Threshold voltage temperature coefficient")
    `MPRco( GAMMA  ,  0.7    , "sqrt(V)" , 0.0 , 2.0 , "Body effect parameter")
    `MPRco( PHI    ,  0.5    , "V"     , 0.2 , 2.0 ,   "Bulk Fermi potential")
    //*** Mobility parameters (long-channel) ***
    `MPRco( KP     ,  150E-6 , "A/V/V" , 0.0 , inf ,   "Transconductance parameter")
    `MPRnb( BEX    ,  -1.5   , ""      ,               "Mobility temperature exponent")
    `MPRco( THETA  ,  0.0    , "1/V"   , 0.0 , inf ,   "Mobility reduction coefficient")
    `MPRco( E0     ,  1.0E8  , "V/m"   , 25e3, inf ,   "Mobility reduction coefficient")
    //*** Velocity sat./channel length mod. parameters (short-channel)
    `MPRco( UCRIT  ,  2.0E6  , "V/m"   , 1e6 , inf ,  "Longitudinal critical field")
    `MPRnb( UCEX   ,  0.8    , ""      ,               "Longitudinal critical field temperature exponent")
    `MPRco( LAMBDA ,  0.8    , ""      , 0.0 , 3.0 ,   "Depletion length coefficient (channel length modulation)")
    //*** Process related parameters
    `MPRnb( DL     , -0.01E-6 , "m"    ,               "Channel width correction")
    `MPRnb( DW     , -0.01E-6 , "m"    ,               "Channel length correction")
    //*** Threshold voltage/substrate effect parameter (narrow-channel)
    `MPRco( WETA   ,  0.2     , ""     , 0.0 , inf ,   "Narrow-channel effect coefficient")
    //*** Threshold voltage/substrate effect parameters (short-channel)
    `MPRco( LETA   ,  0.3     , ""     , 0.0 , inf ,   "Short-channel effect coefficient")
    `MPRco( Q0     ,  230E-6  , "As/m2" , 0.0 , inf ,  "Reverse short channel effect peak charge density")
    `MPRoo( LK     ,  0.4E-6  , "m"    , 0.0 , inf ,   "Reverse short channel effect characteristic length")
    //*** Substrate current parameters
    `MPRco( IBA    ,  5.0E8   , "1/m"  , 0.0 , inf ,   "First impact ionization coefficient")
    `MPRco( IBB    ,  4.0E8   , "V/m"  , 0.0 , inf ,   "Second impact ionization coefficient")
    `MPRnb( IBBT   ,  9.0e-4  , "1/K"  ,               "Temperature coefficient for IBB")
    `MPRco( IBN    ,  1.0     , ""     , 0.0 , inf ,   "Saturation voltage factor for impact ionization")
    //*** Series resistance parameters
    `MPRco( RSH    ,  0.0     , "Ohms" , 0.0 , inf ,   "Sheet resistance")
    `MPRco( HDIF   ,  0.0     , ""     , 0.0 , inf ,   "Sheet resistance multipler")
    //*** for MC analysis fk 25/05/97
    `MPRco( AVTO   ,  1E-6    , "Vm"   , 0.0 , inf ,   "Area related threshold voltage mismatch parameter")
    `MPRco( AKP    ,  1E-6    , "m"    , 0.0 , inf ,   "Area related gain mismatch parameter")
    `MPRco( AGAMMA ,  1E-6    , "sqr(V)m" , 0.0 , inf , "Area related body effect mismatch parameter")
    `MPRco( AF     ,  1.0     , ""     , 0.0 , inf ,   "Flicker noise exponent")
    `MPRco( KF     ,  0.0     , ""     , 0.0 , inf ,   "Flicker noise coefficient")
   // Gate overlap capacitances
    `MPRco( Cgso   , 1.5e-10  , "F/m"   , 0.0  , inf , "gate to source overlap capacitance")
    `MPRco( Cgdo   , 1.5e-10  , "F/m"   , 0.0  , inf , "gate to drain overlap capacitance")
    `MPRco( Cgbo   , 4.0e-10  , "F/m"   , 0.0  , inf , "gate to bulk overlap capacitance")
    //*** JUNCTION DRAIN-BULK AND SOURCE-BULK AREA, CURRENT, CAPACITANCE [AB:040902]
    `MPRco( n          ,  1.0      , "" ,      0.1 , inf  , "")
    `MPRco( js         ,  1.0E-09  , "" ,      0.0 , inf  , "")
    `MPRco( jsw        ,  1.0E-12  , "" ,      0.0 , inf  , "")
    `MPRco( jswg       ,  1.0E-12  , "" ,      0.0 , inf  , "")
    `MPRcc( mj         ,  0.900    , "" ,      0.0 , 1.0  , "")
    `MPRcc( mjsw       ,  0.700    , "" ,      0.0 , 1.0  , "")
    `MPRcc( mjswg      ,  0.700    , "" ,      0.0 , 1.0  , "")
    `MPRco( pb         ,  0.800    , "" ,      0.0 , inf  , "")
    `MPRco( pbsw       ,  0.600    , "" ,      0.0 , inf  , "")
    `MPRco( pbswg      ,  0.600    , "" ,      0.0 , inf  , "")
    `MPRco( cj         ,  1.0E-09  , "" ,      0.0 , inf  , "")
    `MPRco( cjsw       ,  1.0E-12  , "" ,      0.0 , inf  , "")
    `MPRco( cjswg      ,  1.0E-12  , "" ,      0.0 , inf  , "")
    `MPRco( xjbv       ,  0.0      , "" ,      0.0 , inf  , "")
    `MPRco( bv         ,  10.0     , "" ,      0.0 , inf  , "")
    `MPRco( njts       ,  1.0      , "" ,      0.0 , inf  , "")
    `MPRco( njtssw     ,  1.0      , "" ,      0.0 , inf  , "")
    `MPRco( njtsswg    ,  1.0      , "" ,      0.0 , inf  , "")
    `MPRco( vts        ,  0.0      , "" ,      0.0 , inf  , "")
    `MPRco( vtssw      ,  0.0      , "" ,      0.0 , inf  , "")
    `MPRco( vtsswg     ,  0.0      , "" ,      0.0 , inf  , "")
    `MPRoo( xti        ,  3.0      , "" ,     -inf , inf  , "")
    `MPRoo( tcj        ,  0.0      , "" ,     -inf , inf  , "")
    `MPRoo( tcjsw      ,  0.0      , "" ,     -inf , inf  , "")
    `MPRoo( tcjswg     ,  0.0      , "" ,     -inf , inf  , "")
    `MPRoo( tpb        ,  0.0      , "" ,     -inf , inf  , "")
    `MPRoo( tpbsw      ,  0.0      , "" ,     -inf , inf  , "")
    `MPRoo( tpbswg     ,  0.0      , "" ,     -inf , inf  , "")
    `MPRco( tnjts      ,  0.0      , "" ,      0.0 , inf  , "")
    `MPRco( tnjtssw    ,  0.0      , "" ,      0.0 , inf  , "")
    `MPRco( tnjtsswg   ,  0.0      , "" ,      0.0 , inf  , "")

    `OPM(Id, "A", "Drain current")
    `OPM(Ispec, "A", "Specific current") // CE 24/09/20 Added for .OP information
    `OPM(IC, "-", "Inversion coefficient") // CE 24/09/20 Added for .OP information
    `OPM(n0, "-", "Slope factor") // CE 24/09/20 Added for .OP information
    `OPM(gm, "A/V", "Gate transconductance")
    `OPM(gms, "A/V", "Source transconductance") // CE 24/09/20 Added for .OP information
    `OPM(gds, "A/V", "Output conductance")
    `OPM(gmbs, "A/V", "Substrate conductance")
    `OPM(Rn, "Ohm", "Input-referred thermal noise resistance") // CE 24/09/20 Added for .OP information
    `OPM(Vnth, "V/sqrt(Hz)", "Input-referred thermal noise voltage") // CE 24/09/20 Added for .OP information
    `OPM(gamman, "-", "Thermal noise excess factor") // CE 24/09/20 Added for .OP information
    `OPM(Vnfl, "V/sqrt(Hz)", "Input-referred flicker noise voltage at 1 Hz") // CE 24/09/20 Added for .OP information
    `OPP(Vdsat, "V", "Saturation voltage")

    analog begin
        `INITIAL_MODEL
        begin : modelInitialization
            // Set constant
//            EPSOX  = 3.9 * `P_EPS0;
            epssil = 11.7 * `P_EPS0;
            // The following are necessary to prevent memory states being reserved:
//            Ibd = 0.0;
//            THETA_VP_1 = 0.0;
//            VPprime = 0.0;
//            sqrt_VP_Vt = 0.0;
            // Geometry, voltage and temperature independent model variables
            eps_COX = epssil/COX;
            Lc  = sqrt(eps_COX*XJ);
            Lc_LAMBDA  = Lc * LAMBDA;
            eps_COX_W = 3.0 * eps_COX * WETA;
            eps_COX_L = eps_COX * LETA;
            IBN_2 = IBN + IBN;
            T0 = COX / (epssil*E0);
            V0 = (Q0+Q0) / COX;
            eta_qi = TYPE > 0 ? 0.5 : 0.3333333333333;
        end
        `INITIAL_INSTANCE
        begin : instanceInitialization
            /* Model working variables, geometry and voltage independent,
             * which need to be updated after temperature change
             * EKV model internal variables depending on temperature.
             */
            /* If Temp is explicitly specified, use that value
               otherwise use Tckt+Trise */
            if ($param_given(TEMP) == 0)    //AB: 040902 Temp -> TEMP
                T = $temperature + DTEMP;
            else
                T = TEMP + `P_CELSIUS0;
            if ($param_given(TNOM) == 0)
                Tnom = `DEFAULT_TNOM + `P_CELSIUS0;
            else
                Tnom = TNOM + `P_CELSIUS0;
            Vt = $vt(T);
            Vt_01 = 0.1 * Vt;
            inv_Vt = 1.0 / Vt;
            Vt_2 = Vt + Vt;
            Vt_4 = Vt_2 + Vt_2;
            Vt_Vt = Vt * Vt;
            Vt_Vt_2 = Vt_Vt + Vt_Vt;
            Vt_Vt_16 = 16.0 * Vt_Vt;
            Eg = 1.16 - 7.02e-4 * T * T / (T + 1108.0);
            refEg = 1.16 - (7.02e-4*Tnom*Tnom) / (Tnom + 1108.0);
            deltaT = T - Tnom;
            ratioT = T / Tnom;
            VTO_T = VTO - TCV * deltaT;
            KP_T = KP * pow(ratioT, BEX);
            UCRIT_T = UCRIT * pow(ratioT, UCEX);
            IBB_T = IBB * (1.0 + IBBT * deltaT);
            PHI_T = PHI * ratioT - 3.0 * Vt * ln(ratioT) - refEg * ratioT + Eg;
            //  !!  mb  99/07/30  prevents PHI from becoming smaller than 0.2
            tmp1 = 0.2;
            tmp2 = PHI_T - tmp1;
            PHI_T = 0.5*(tmp2 + sqrt(tmp2*tmp2 + Vt*Vt)) + tmp1;
            sqrt_PHI = sqrt(PHI_T);
            inv_UCRIT = 1.0/UCRIT_T;
            Lc_UCRIT  = Lc * UCRIT_T;
            Lc_IBB  = Lc * IBB_T;
            IBA_IBB = IBA / IBB_T;
            /* VTO, KP and GAMMA with variation for MC analysis if required.
             * The default value for model parameters AVTO, AKP and AGAMMA
             * is set to 1e-6 to allow meaningful sensitivity analysis. Only
             * the deviation from this value has to be taken into account
             */
            // wg: for userc.c and verilog implementations
            Leff = L + DL;
            // wg: for userc.c and verilog implementations
            Weff = W + DW;
            Vc = UCRIT_T*Leff;   //  NOTE: use L if necessary
            log_Vc_Vt = Vt*(ln(0.5*Vc*inv_Vt)-0.6);   //    mb  98/02/05  (r1)
            // de-normalization
            AWL = 1.0/sqrt(Weff*Leff);
            if (TYPE > 0)
                VTO_S  = ((AVTO != 1e-6) ? AWL*(AVTO - 1e-6) + VTO_T : VTO_T);
            else
                VTO_S  = ((AVTO != 1e-6) ? AWL*(1e-6 - AVTO) - VTO_T: -VTO_T);
            KP_Weff = Weff * ((AKP != 1e-6) ? KP_T*(1 + (AKP - 1e-6)*AWL) : KP_T);
            GAMMA_S = ((AGAMMA !=1e-6) ? GAMMA + (AGAMMA - 1e-6)*AWL : GAMMA);
            GAMMA_sqrt_PHI = GAMMA_S*sqrt_PHI;
            /* ************************************
             *     STATIC MODEL EQUATIONS
             * *************************************/
            //  VGprime:
            if (V0 == 0.0)
                deltaVFB = 0.0;
            else begin  : VGprime_block //AB: 040902 VGPrime ->  VGprime_block
                real sqv;
                // mb  99/03/26  corrected for multiple device number
                vL = 0.28 * (Leff/(LK*NS) - 0.1);
                sqv = 1.0 / (1.0 + 0.5*(vL + sqrt(vL*vL + 1.936e-3)));
                deltaVFB = V0 * sqv * sqv;
            end
        end

        VG = TYPE * V(g,b); // wg 22/04/08 corrected for device TYPE
        VS = TYPE * V(s,b);
        VD = TYPE * V(d,b);
        if (VD - VS < 0) begin
            Mode = `REV;
            T1 = VS;
            VS = VD;
            VD = T1;
        end
        else
            Mode = `FWD;
        // VGB   = VGS - VBS;
        // VBD   = VBS - VDS;
        VGstar = VG - VTO_S - deltaVFB + PHI_T + GAMMA_sqrt_PHI;
        sqrt_VGstar = sqrt(VGstar*VGstar + 2.0*Vt_Vt_16);
        VGprime = 0.5*(VGstar + sqrt_VGstar);
        //  Pinch-off voltage VP, limited to VP >= -PHI
        PHI_VS = PHI_T+VS;
        sqrt_PHI_VS_Vt = sqrt(PHI_VS*PHI_VS+Vt_Vt_16);
        sqrt_PHI_VS = sqrt(0.5*(PHI_VS+sqrt_PHI_VS_Vt));
        PHI_VD = PHI_T+VD;
        sqrt_PHI_VD_Vt = sqrt(PHI_VD*PHI_VD+Vt_Vt_16);
        sqrt_PHI_VD = sqrt(0.5*(PHI_VD+sqrt_PHI_VD_Vt));
        WETA_W  = eps_COX_W * M / Weff;
        LETA_L  = eps_COX_L * NS / Leff;
        // mb: symmetric version of GAMMAprime necessary with charges model
        big_sqrt_VP0 = sqrt(VGprime + 0.25*GAMMA_S*GAMMA_S);
        VP0 = VGprime - PHI_T - GAMMA_S*(big_sqrt_VP0 - 0.5*GAMMA_S);
        sqrt_PHI_VP0 = sqrt(VP0+PHI_T+Vt_01);
        GAMMAstar = GAMMA_S - LETA_L * (sqrt_PHI_VS+sqrt_PHI_VD) +
            WETA_W * sqrt_PHI_VP0;
        // keep GAMMAprime from becoming negative
        sqrt_GAMMAstar = sqrt(GAMMAstar*GAMMAstar+Vt_01);
        GAMMAprime = 0.5*(GAMMAstar+sqrt_GAMMAstar);
        big_sqrt_VP = sqrt(VGprime+0.25*GAMMAprime*GAMMAprime);
        VP = VGprime-PHI_T-GAMMAprime*(big_sqrt_VP-0.5*GAMMAprime);
        // Forward normalized current:
        tmp1  = (VP - VS) * inv_Vt;

        `y_fv(tmp1,yk)

        if_     = yk*(1.0 + yk);
        IC = if_; // 24/09/20 CE Added for operating point information
        sqrt_if = sqrt(if_);
        dif_dv  = yk;
        //  Saturation voltage:
        Vt_Vc = Vt / Vc;
        VDSS_sqrt = sqrt(0.25+sqrt_if*Vt_Vc);
        VDSS = Vc*(VDSS_sqrt-0.5);
        Vds = 0.5*(VD-VS);
        deltaV_2 = Vt_Vt_16*(LAMBDA*(sqrt_if-
            VDSS*inv_Vt)+15.625e-3);
        sqrt_VDSS_deltaV = sqrt(VDSS*VDSS+deltaV_2);
        sqrt_Vds_VDSS_deltaV = sqrt((Vds-VDSS)*(Vds-VDSS)+deltaV_2);
        Vip = sqrt_VDSS_deltaV-sqrt_Vds_VDSS_deltaV;
        VDSSprime_sqrt = sqrt(0.25+(sqrt_if-0.75*ln(if_))*Vt_Vc);
        VDSSprime = Vc*(VDSSprime_sqrt-0.5)+log_Vc_Vt;
        //  Reverse normalized current:
        Vdsprime = Vds-VDSSprime;   //    mb  97/07/18  introduced Vdsprime
        sqrt_VDSSprime_deltaV = sqrt(VDSSprime*VDSSprime+deltaV_2);
        sqrt_Vds_VDSSprime_deltaV = sqrt(Vdsprime*Vdsprime+deltaV_2);
        tmp1 = (VP-Vds-VS-sqrt_VDSSprime_deltaV+
            sqrt_Vds_VDSSprime_deltaV)*inv_Vt;
        // include -> Charge F(x) interpolate function

        `y_fv(tmp1,yk)

        irprime       = yk*(1.0 + yk);
//        sqrt_irprime  = sqrt(irprime);
        dirprime_dv   = yk;
        /* Channel length modulation & mobility reduction due
         * to longitudinal field */
        deltaL = Lc_LAMBDA*ln(1.0+(Vds-Vip)/Lc_UCRIT);
        Lprime = Leff-deltaL+(Vds+Vip)*inv_UCRIT;
        Lmin = 0.1*Leff;
        sqrt_Lprime_Lmin = sqrt(Lprime*Lprime+Lmin*Lmin);
        Leq = 0.5*(Lprime+sqrt_Lprime_Lmin);
        // Transconductance factor:
        // Mobility reduction due to vertical field
        // Reverse normalized current:
        // ratioV_ir
        tmp1 = (VP - VD) * inv_Vt;

        `y_fv(tmp1,yk)

        ir      = yk*(1.0 + yk);
//        sqrt_ir = sqrt(ir);
        dir_dv  = yk;
        sif2 = 0.25+if_;
        sir2 = 0.25+ir;
        sif = sqrt(sif2);
        sir = sqrt(sir2);
        sif_sir_2 = (sif+sir)*(sif+sir);
        VP_PHI_eps = VP+PHI_T+1.0e-6;
        sqrt_PHI_VP_2 = 2.0*sqrt(VP_PHI_eps);
        n_1 = GAMMA_S/sqrt_PHI_VP_2;
        n_1_n = GAMMA_S/(sqrt_PHI_VP_2 + GAMMA_S);
        //  Normalized inversion charge  (qi=QI/WLCox)
        qi = -(1.0+n_1)*Vt*((0.66666666+0.66666666)*
            (sir2+sir*sif+sif2)/(sif+sir) - 1.0);
        // Normalized depletion charge (qb=QB/WLCox), for depletion to inversion
        qb = -0.5*GAMMA_S*sqrt_PHI_VP_2 - n_1_n*qi;
        if (E0 == 0.0) begin
            /*  NOTE: this version of the simple mobility model from prior
             *  versions of the EKV model is reinstated.
             *  In case E0 is *not* specified, this
             *  simple mobility model is used according to THETA, if specified.
             *  VPprime:
             *  mb  eliminated discontinuity of derivative of 1+THETA*VP
             */
            sqrt_VP_Vt = sqrt(VP*VP + Vt_Vt_2);
            VPprime = 0.5 * (VP + sqrt_VP_Vt);
            THETA_VP_1 = 1.0+THETA*VPprime;
            beta = KP_Weff  / (Leq * THETA_VP_1); // mb  97/07/18
        end
        else begin
            /*  new model for mobility reduction, linked to the charges model
             *  mb  98/10/11  (r10)  introduced fabs(Eeff) (jpm)
             *  E0_Q_1 = 1.0 + T0 * abs(qb+eta_qi*qi);
             */
            if ((qb + eta_qi*qi) > 0.0)
                E0_Q_1 = 1.0 + T0*(qb + eta_qi*qi);
            else
                E0_Q_1 = 1.0 - T0*(qb + eta_qi*qi);
            T0_GAMMA_1 = 1.0 + T0*GAMMA_sqrt_PHI;
            beta = KP_Weff * T0_GAMMA_1 / (Leq * E0_Q_1);
        end
        /* Slope factor: mb introduced new formula to avoid divergence
         * of nslope for VP->-PHI  */
        sqrt_PHI_VP = sqrt(PHI_T+VP+Vt_4);   //    mb  95/12/19  introduced Vt_4
        nslope = 1.0 + GAMMA_S/(2.0*sqrt_PHI_VP);
        n0 = 1.0 + GAMMA_S/(2.0*sqrt_PHI); // 24/09/20 CE Added for operating point information
        //  Drain current:
        if_ir = if_-irprime;
        Ispec = Vt_Vt_2 * nslope * beta;
        Id = Ispec * if_ir;
        /* Return threshold voltage
         * Von = Vth(Vs) = Vto + Gamma*(sqrt(Phi + Vsb)-sqrt(Phi)) */
//        Von = VTO_S + GAMMAprime*(sqrt_PHI_VS - sqrt_PHI);
        // Return saturation voltage (estimate)
        Vdsat = Vt * (2.0*sqrt_if + 4.0);
        // Return equivalent conductance for thermal noise calculation
        Gn  = beta * abs(qi);
        /*  Pinch-off voltage derivatives:
         *  mb  97/09/14  symmetric version of GAMMAprime necessary with
         *  charges model
         *  mb  99/05/10  (r12) New VGprime formulation (REVISION III) allows
         *  VP derivatives to be expressed with a single equation
         */
        tmp1 = GAMMAprime / (sqrt_GAMMAstar+sqrt_GAMMAstar);
        tmp2 = VGprime/sqrt_VGstar;                        //  dVGprime_dVG
        dGAMMAprime_dVD = -LETA_L * tmp1 * sqrt_PHI_VD / sqrt_PHI_VD_Vt;
        dGAMMAprime_dVS = -LETA_L * tmp1 * sqrt_PHI_VS / sqrt_PHI_VS_Vt;
        dGAMMAprime_dVG =  WETA_W * tmp1 * (big_sqrt_VP0-0.5*GAMMA_S) /
            (big_sqrt_VP0*sqrt_PHI_VP0) * tmp2;
        tmp3 = (VP+PHI_T) / big_sqrt_VP;
        dVP_dVD = -tmp3 * dGAMMAprime_dVD;
        dVP_dVS = -tmp3 * dGAMMAprime_dVS;
        dVP_dVG = -tmp3 * dGAMMAprime_dVG + (1.0 -
            GAMMAprime/(big_sqrt_VP+big_sqrt_VP)) * tmp2;
        //  Forward normalized current derivatives:
        tmp1 = dif_dv * inv_Vt;   //    mb  95/08/28, 97/04/21
        dif_dVD = tmp1 * dVP_dVD;
        dif_dVS = tmp1 * (dVP_dVS-1.0);
        dif_dVG = tmp1 * dVP_dVG;
        //  Saturation voltage derivatives:
        tmp1 = Vt / (4.0*VDSS_sqrt*sqrt_if);
        dVDSS_dVD = tmp1 * dif_dVD;
        dVDSS_dVS = tmp1 * dif_dVS;
        dVDSS_dVG = tmp1 * dif_dVG;
        //  deltaV derivatives:
        tmp1 = (Vt_4+Vt_4) * LAMBDA;
        tmp2 = Vt / (sqrt_if+sqrt_if);
        ddeltaV_dVD = tmp1 * (dif_dVD*tmp2 - dVDSS_dVD);
        ddeltaV_dVS = tmp1 * (dif_dVS*tmp2 - dVDSS_dVS);
        ddeltaV_dVG = tmp1 * (dif_dVG*tmp2 - dVDSS_dVG);
        //  Vip derivatives:
        tmp1 = 1.0 / sqrt_VDSS_deltaV;
        tmp2 = 1.0 / sqrt_Vds_VDSS_deltaV;
        tmp3 = Vds-VDSS;
        dVip_dVD = (VDSS*dVDSS_dVD + ddeltaV_dVD) * tmp1 -
            (tmp3 * (0.5-dVDSS_dVD) + ddeltaV_dVD) * tmp2;
        dVip_dVS = (VDSS*dVDSS_dVS + ddeltaV_dVS) * tmp1 -
            (tmp3 * (-0.5-dVDSS_dVS) + ddeltaV_dVS) * tmp2;
        dVip_dVG = (VDSS*dVDSS_dVG + ddeltaV_dVG) * tmp1 -
            (tmp3 * -dVDSS_dVG + ddeltaV_dVG) * tmp2;
        //  VDSSprime derivatives:
        tmp1 = Vt * (sqrt_if-1.5)/(4.0*VDSSprime_sqrt*if_);
        dVDSSprime_dVD = tmp1 * dif_dVD;
        dVDSSprime_dVS = tmp1 * dif_dVS;
        dVDSSprime_dVG = tmp1 * dif_dVG;
        //  Reverse normalized current derivatives:
        tmp1 = dirprime_dv * inv_Vt;   //    mb  95/08/28,  97/04/21
        tmp2 = 1.0 / sqrt_VDSSprime_deltaV;        //    mb  97/04/21
        tmp3 = 1.0 / sqrt_Vds_VDSSprime_deltaV;
        dirprime_dVD = tmp1 * (dVP_dVD-0.5 -
            (VDSSprime*dVDSSprime_dVD+ddeltaV_dVD) * tmp2 +
            (Vdsprime*(0.5-dVDSSprime_dVD)+ddeltaV_dVD) * tmp3);
        dirprime_dVS = tmp1 * (dVP_dVS-0.5 -
            (VDSSprime*dVDSSprime_dVS+ddeltaV_dVS) * tmp2 +
            (Vdsprime*(-0.5-dVDSSprime_dVS)+ddeltaV_dVS) * tmp3);
        dirprime_dVG = tmp1*(dVP_dVG -
            (VDSSprime*dVDSSprime_dVG+ddeltaV_dVG) * tmp2 +
            (Vdsprime*(-dVDSSprime_dVG)+ddeltaV_dVG) * tmp3);
        //  Channel length modulation & mobility reduction derivatives:
        //  deltaL derivatives:
        tmp1 = Lc_LAMBDA / (Lc_UCRIT+Vds-Vip);
        ddeltaL_dVD = tmp1 * (0.5-dVip_dVD);
        ddeltaL_dVS = tmp1 * (-0.5-dVip_dVS);
        ddeltaL_dVG = -tmp1 * dVip_dVG;
        //  Leq derivatives:
        tmp1 = 1.0 / sqrt_Lprime_Lmin; //  in fact dLeq_dVX/Leq
        dLeq_dVD = tmp1 * (-ddeltaL_dVD + (0.5+dVip_dVD)*inv_UCRIT);
        dLeq_dVS = tmp1 * (-ddeltaL_dVS + (-0.5+dVip_dVS)*inv_UCRIT);
        dLeq_dVG = tmp1 * (-ddeltaL_dVG + dVip_dVG*inv_UCRIT);
        //  Transconductance factor derivatives:
        tmp1 = dir_dv*inv_Vt;
        dir_dVD = tmp1 * (dVP_dVD-1.0);
        dir_dVS = tmp1 * dVP_dVS;
        dir_dVG = tmp1 * dVP_dVG;
        tmp1 = -(1.0+n_1)*Vt*0.66666666/sif_sir_2;
        tmp2 = tmp1*(sif+2.0*sir);
        tmp3 = tmp1*(sir+2.0*sif);
        tmp1 = -n_1*qi/((2.0+n_1+n_1)*VP_PHI_eps);
        dQI_dVD = tmp1 * dVP_dVD + tmp2 * dif_dVD + tmp3 * dir_dVD;
        dQI_dVS = tmp1 * dVP_dVS + tmp2 * dif_dVS + tmp3 * dir_dVS;
        dQI_dVG = tmp1 * dVP_dVG + tmp2 * dif_dVG + tmp3 * dir_dVG;
        tmp1 = (1.0+n_1)-qi/(2.0*(1.0+n_1)*VP_PHI_eps);
        dQB_dVD = -n_1_n * (tmp1 * dVP_dVD + dQI_dVD);
        dQB_dVS = -n_1_n * (tmp1 * dVP_dVS + dQI_dVS);
        dQB_dVG = -n_1_n * (tmp1 * dVP_dVG + dQI_dVG);
        if (E0 == 0.0) begin
            tmp1 = THETA * VPprime / (THETA_VP_1 * sqrt_VP_Vt);
            //  VPprime derivatives:
            dVPprime_dVD = tmp1 * dVP_dVD;
            dVPprime_dVS = tmp1 * dVP_dVS;
            dVPprime_dVG = tmp1 * dVP_dVG;
            dbeta_dVD = -dLeq_dVD - dVPprime_dVD;  //  in fact dbeta_dVX / beta
            dbeta_dVS = -dLeq_dVS - dVPprime_dVS;
            dbeta_dVG = -dLeq_dVG - dVPprime_dVG;
        end
        else begin
            tmp1 = T0 / E0_Q_1;
            dbeta_dVD = -dLeq_dVD + tmp1 * (dQB_dVD+eta_qi*dQI_dVD);
            dbeta_dVS = -dLeq_dVS + tmp1 * (dQB_dVS+eta_qi*dQI_dVS);
            dbeta_dVG = -dLeq_dVG + tmp1 * (dQB_dVG+eta_qi*dQI_dVG);
        end
        //  Slope factor derivatives:
        tmp1 = -GAMMA_S/(4.0*nslope*sqrt_PHI_VP*(PHI_T+VP+Vt_4));//    mb  95/12/19
        dn_dVD = tmp1 * dVP_dVD;
        dn_dVS = tmp1 * dVP_dVS;
        dn_dVG = tmp1 * dVP_dVG;
        //  Transconductances:
        gds =  Ispec*((dn_dVD + dbeta_dVD)*if_ir + dif_dVD - dirprime_dVD);
        gms = -Ispec*((dn_dVS + dbeta_dVS)*if_ir + dif_dVS - dirprime_dVS);
        gm =   Ispec*((dn_dVG + dbeta_dVG)*if_ir + dif_dVG - dirprime_dVG);
        gmbs = gms - gm - gds;
        Rn = Gn/(gm*gm); // CE 24/09/20 Added for .OP information
        gamman = gm*Rn; // CE 24/09/20 Added for .OP information
        Vnth = sqrt(4 * `P_K * T * Rn); // CE 24/09/20 Added for .OP information
        Vnfl = sqrt(KF / (Weff * NS * Leff * COX)); // CE 24/09/20 Added for .OP information
        // S/D resistance corrections including W and DW
        if ($param_given(HDIF)==1) begin
            RSeff = (RSH*HDIF)/(Weff-DW);
            RDeff = (RSH*HDIF)/(Weff-DW);
        end else begin
            RSeff = RSH*NRS;
            RDeff = RSH*NRD;
        end
        tmp1 = 1.0/(1.0 + gms*RSeff + gds*RDeff);
        Id = Id*tmp1;
        /******   Impact ionization current     ******
         * mb  95/12/19  introduced impact ionization
         * This current component is flowing from the intrinsic drain terminal
         * to the bulk (for NMOS) in parallel with the junction current.
         * The simulator should also take into account the corresponding
         * conductances.
         */
        //  Substrate current:
        Vib = VD-VS-IBN_2*VDSS;
        if ((Vib > 0.0) && (IBA_IBB > 0.0)) begin
            inv_Vib = 1.0/Vib;
            Lc_IBB_Vib = -Lc_IBB*inv_Vib;
            if (Lc_IBB_Vib < -35.0) // math precision check
                Lc_IBB_Vib = -35.0;
            exp_ib = exp(Lc_IBB_Vib);
            isub = IBA_IBB*Vib*exp_ib;
            Isub = isub*Id;
//            dIsub_factor = Isub*inv_Vib*(1.0-Lc_IBB_Vib);
        end
        else begin
            Lc_IBB_Vib = 0.0;
            Isub = 0.0;
        end
        // END: substrate current computation
//        Ibd = Ibd - Isub;
        // --- Charge calculations ---
        WLCox = Weff * Leff * COX;
        sif3 = sif*sif2;
        sir3 = sir*sir2;
        tmp1 = sqrt(PHI_T + 0.5 * VP);
        sqrt_PHI_VP2_2 = tmp1+tmp1;
        n_Vt_COX = (1.0 + GAMMAprime/sqrt_PHI_VP2_2) * Vt*WLCox;
        QD = -n_Vt_COX*(0.266666666*(3.0*sir3+6.0*sir2*sif+4.0*
            sir*sif2+2.0*sif3)/sif_sir_2 - 0.5);
        QS = -n_Vt_COX*(0.266666666*(3.0*sif3+6.0*sif2*sir+4.0*
            sif*sir2+2.0*sir3)/sif_sir_2 - 0.5);
        QI = QS + QD;
        QB = WLCox * (-0.5*GAMMAprime*sqrt_PHI_VP_2 + VGprime - VGstar) -
            QI*GAMMAprime/(GAMMAprime+sqrt_PHI_VP2_2);
        QG = -QI -QB;
        I(ds) <+ TYPE * Mode * Id;          // wg 22/04/08 corrected for device TYPE
        if (Mode == `FWD) begin
            Qbdx = QD;
            Qbsx = QS;
            I(db) <+ TYPE * Isub;
        end
        else begin
            Qbdx = QS;
            Qbsx = QD;
            I(sb) <+ TYPE * Isub;
        end
        I(db) <+ TYPE * ddt(Qbdx);          // wg 22/04/08 corrected for device TYPE
        I(sb) <+ TYPE * ddt(Qbsx);
        I(gb) <+ TYPE * ddt(QG);            // wg 22/04/08 corrected for device TYPE
        if (Noise) begin : Noise_block      //AB: 040902 Noise ->  Noise_block
            real S_flicker, S_thermal;
            S_thermal = 4 * `P_K * T * Gn;
            S_flicker = KF * gm * gm / (Weff * NS * Leff * COX);
            I(ds) <+ white_noise(S_thermal, "thermal");
            I(ds) <+ flicker_noise(S_flicker, AF, "flicker");
        end
        ///////////////////////////////////
        //EXTRINSIC PART: JUNCTION DIODES//
        ///////////////////////////////////
    //diode area and perimeter computation
        if (($param_given(AS)==0) && ($param_given(HDIF)==1)) as_i = 2.0*HDIF*Weff;
        else as_i = AS;
        if (($param_given(PS)==0) && ($param_given(HDIF)==1)) ps_i = 4.0*HDIF+1.0*Weff;
        else ps_i = PS;
        if (($param_given(AD)==0) && ($param_given(HDIF)==1)) ad_i = 2.0*HDIF*Weff;
        else ad_i = AD;
        if (($param_given(PD)==0) && ($param_given(HDIF)==1)) pd_i = 4.0*HDIF+1.0*Weff;
        else pd_i = PD;
    //temperature update for diodes
        temp_arg = exp((refEg/$vt(Tnom) - Eg/Vt + xti*ln(ratioT))/n);
        js_t = js*temp_arg;
        jsw_t = jsw*temp_arg;
        jswg_t = jswg*temp_arg;
        pb_t = pb - tpb*deltaT;
        pbsw_t = pbsw - tpbsw*deltaT;
        pbswg_t = pbswg - tpbswg*deltaT;
        cj_t = cj*(1.0+tcj*deltaT);
        cjsw_t = cjsw*(1.0+tcjsw*deltaT);
        cjswg_t = cjswg*(1.0+tcjswg*deltaT);
        njts_t = njts*(1.0+(ratioT-1.0)*tnjts);
        njtssw_t = njtssw*(1.0+(ratioT-1.0)*tnjtssw);
        njtsswg_t = njtsswg*(1.0+(ratioT-1.0)*tnjtsswg);
        //DC
        Vtn = Vt*n;
    //DRAIN - BULK
        is_d = js_t*ad_i+jsw_t*pd_i+jswg_t*Weff;
`ifdef __NGSPICE__
        if (TYPE == 1) begin
            v_di_b = $limit(V(d,b), "pnjlim", Vtn, Vtn*ln(Vtn/(`M_SQRT2*is_d)));
        end else begin
            v_di_b = $limit(V(b,d), "pnjlim", Vtn, Vtn*ln(Vtn/(`M_SQRT2*is_d)));
        end
`else
        v_di_b = TYPE*V(d,b);
`endif
        arg_d = -v_di_b*ratioT/(Vtn);
        if (arg_d < -40.0) arg_d = -40.0;
        tmp0 = (-v_di_b+bv)*ratioT/(Vtn);
        if (tmp0>70) f_breakdown_d = 1.0;
        else f_breakdown_d = 1.0 + xjbv*exp(-tmp0);
    // TRAP-ASSISTED TUNNELING CURRENT
        idb_tun = -Weff*jswg_t*(limexp(v_di_b*ratioT/(Vt*njtsswg_t) * vtsswg/max(vtsswg+v_di_b,1.0e-3))-1.0);
        idb_tun = idb_tun - pd_i*jsw_t*(limexp(v_di_b*ratioT/(Vt*njtssw_t) * vtssw/max(vtssw+v_di_b,1.0e-3))-1.0);
        idb_tun = idb_tun - ad_i*js_t*(limexp(v_di_b*ratioT/(Vt*njts_t) * vts/max(vts+v_di_b,1.0e-3))-1.0);
//        I(d,b) <+ (is_d * (1.0 - limexp(arg_d))*f_breakdown_d+v_di_b*`GMIN + idb_tun)*TYPE*M;
        I(d,b) <+ (is_d * (1.0 - limexp(arg_d))*f_breakdown_d)*TYPE*M; //ce 24/09/20 turned off the tuneling current for better match to the Smash implementation
    //SOURCE - BULK
        is_s = js_t*as_i+jsw_t*ps_i+jswg_t*Weff;
`ifdef __NGSPICE__
        if (TYPE == 1) begin
            v_si_b = $limit(V(s,b), "pnjlim", Vtn, Vtn*ln(Vtn/(`M_SQRT2*is_s)));
        end else begin
            v_si_b = $limit(V(b,s), "pnjlim", Vtn, Vtn*ln(Vtn/(`M_SQRT2*is_s)));
        end
`else
        v_si_b = TYPE*V(s,b);
`endif
        arg_s = -v_si_b*ratioT/(Vtn);
        if (arg_s < -40.0) arg_s = -40.0;
        tmp0 = (-v_si_b+bv)*ratioT/(Vtn);
        if (tmp0>70) f_breakdown_s = 1.0;
        else f_breakdown_s = 1.0 + xjbv*exp(-tmp0);
    // TRAP-ASSISTED TUNNELING CURRENT
        isb_tun = -Weff*jswg_t*(limexp(v_si_b*ratioT/(Vt*njtsswg_t) * vtsswg/max(vtsswg+v_si_b,1.0e-3))-1.0);
        isb_tun = isb_tun - ps_i*jsw_t*(limexp(v_si_b*ratioT/(Vt*njtssw_t) * vtssw/max(vtssw+v_si_b,1.0e-3))-1.0);
        isb_tun = isb_tun - as_i*js_t*(limexp(v_si_b*ratioT/(Vt*njts_t) * vts/max(vts+v_si_b,1.0e-3))-1.0);
//        I(s,b) <+ (is_s * (1.0 - limexp(arg_s))*f_breakdown_s+v_si_b*`GMIN + isb_tun)*TYPE*M;
        I(s,b) <+ (is_s * (1.0 - limexp(arg_s))*f_breakdown_s)*TYPE*M; //ce 24/09/20 turned off the tuneling current for better match to the Smash implementation
    //AC

    //DRAIN - BULK
        if (v_di_b>0.0)
        begin
            csb_d  = cj_t   * ad_i * exp(-mj*ln(1.0+v_di_b/pb_t));
            cssw_d = cjsw_t * pd_i * exp(-mjsw*ln(1.0+v_di_b/pbsw_t));
            csswg_d = cjswg_t * Weff * exp(-mjswg*ln(1.0+v_di_b/pbswg_t));
        end
        else
        begin
            csb_d  = cj_t   * ad_i * (1.0 - mj*v_di_b/pb_t);
            cssw_d = cjsw_t * pd_i * (1.0 - mjsw*v_di_b/pbsw_t);
            csswg_d = cjswg_t * Weff * (1.0 - mjswg*v_di_b/pbswg_t);
        end
        qjd = (csb_d+cssw_d+csswg_d) * v_di_b;
        I(d,b) <+ ddt(qjd)*TYPE*M;
    //SOURCE - BULK
        if (v_si_b>0.0)
        begin
            csb_s  = cj_t   * as_i * exp(-mj*ln(1.0+v_si_b/pb_t));
            cssw_s = cjsw_t * ps_i * exp(-mjsw*ln(1.0+v_si_b/pbsw_t));
            csswg_s = cjswg_t * Weff * exp(-mjswg*ln(1.0+v_si_b/pbswg_t));
        end
        else
        begin
            csb_s  = cj_t   * as_i * (1.0 - mj*v_si_b/pb_t);
            cssw_s = cjsw_t * ps_i * (1.0 - mjsw*v_si_b/pbsw_t);
            csswg_s = cjswg_t * Weff * (1.0 - mjswg*v_si_b/pbswg_t);
        end
        qjs = (csb_s+cssw_s+csswg_s) * v_si_b;
        I(s,b) <+ ddt(qjs)*TYPE*M;
    //END OF DIODES

        // Overlap capacitances
        qgso = Cgso*Weff*V(g,s);
        qgdo = Cgdo*Weff*V(g,d);
        qgbo = Cgbo*Leff*V(g,b);
        I(g,s) <+ M*TYPE*ddt(qgso);
        I(g,d) <+ M*TYPE*ddt(qgdo);
        I(g,b) <+ M*TYPE*ddt(qgbo);

    end
endmodule
